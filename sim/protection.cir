* Защита входа перехватчика: где ставить супрессор относительно диода
*
* Зачем эта модель. Вопрос не умозрительный: при сбросе нагрузки ток выброса
* должен куда-то уйти, и от места супрессора зависит, потечёт он ЧЕРЕЗ диод
* Шоттки или мимо него. У 1N5822 предел по одиночному импульсу около 80 А за
* 8 мс, а сброс нагрузки длится сотни миллисекунд - разница принципиальная.
*
* Считаются две цепочки от одного источника:
*   ветка A - супрессор ПОСЛЕ диода (как было у меня в схеме)
*   ветка B - супрессор ДО диода
* Сравнивать i(vmonA) и i(vmonB) - ток через диод в каждой.
*
* Запуск:
*   sudo pacman -S ngspice
*   ngspice -b sim/protection.cir
*
* Импульс взят по мотивам ISO 7637-2 pulse 5 в мягком варианте: 60 В с
* внутренним сопротивлением 1 Ом и спадом за ~200 мс. Настоящий бывает злее,
* но для сравнения двух топологий этого достаточно.

.title Protection front-end, TVS placement

* --- источник: 14.4 В, затем выброс 60 В со спадом ------------------------
Vbat bat 0 PWL(0 14.4  99m 14.4  100m 60  300m 20  320m 14.4  600m 14.4)
Rsrc bat src 1

* --- предохранитель: сопротивление проводки и колодки ---------------------
Rfuse src fused 0.05

* ======================= ветка A: супрессор ПОСЛЕ диода ===================
* Ток выброса вынужден идти через диод, потому что уйти на массу он может
* только за ним.
VmonA fused a_an 0
DA1 a_an a_vin DSCHOTTKY
DTA 0 a_vin DTVS
CA a_vin 0 100u
RloadA a_vin 0 30

* ======================= ветка B: супрессор ДО диода ======================
* Выброс уходит на массу сразу после предохранителя, и диод его не видит.
VmonB fused b_an 0
DTB 0 b_an DTVS
DB1 b_an b_vin DSCHOTTKY
CB b_vin 0 100u
RloadB b_vin 0 30

* --- модели ---------------------------------------------------------------
* Шоттки 1N5822: малое падение, 40 В обратного
.model DSCHOTTKY D(IS=2e-5 N=1.05 RS=0.02 BV=40 CJO=300p)
* Супрессор 1.5KE18CA: пробой 18 В, ограничение около 25 В на больших токах
.model DTVS D(IS=1e-12 N=1.2 RS=0.12 BV=18 IBV=1e-3 CJO=2n)

.control
  set noaskquit
  tran 100u 600m
  echo ""
  echo "=== напряжение на входе преобразователя, максимум ==="
  meas tran vmax_a  MAX v(a_vin)
  meas tran vmax_b  MAX v(b_vin)
  echo ""
  echo "=== ток через диод Шоттки, максимум ==="
  meas tran imax_a  MAX i(VmonA)
  meas tran imax_b  MAX i(VmonB)
  echo ""
  echo "=== заряд через диод за выброс (мера нагрева) ==="
  meas tran q_a INTEG i(VmonA) FROM=0.099 TO=0.35
  meas tran q_b INTEG i(VmonB) FROM=0.099 TO=0.35
  echo ""
  echo "Предел по входу у MP1584EN - 28 В. Одиночный импульс 1N5822 - около 80 А."
.endc

.end
